# Ansys Electronics Desktop project, version 2022.2
materials:
  air: permittivity=1.0006 permeability=1.0000004
  copper: permeability=0.999991 conductivity=58000000
  FR4_epoxy: permittivity=4.4 dielectric_loss_tangent=0.02
  FR4_PCBWay: permittivity=4.29 dielectric_loss_tangent=0.02
  FR4_PCBWay_Core: permittivity=4.6 dielectric_loss_tangent=0.02
  pec: conductivity=1e+30
  SolderMask: permittivity=3.1 dielectric_loss_tangent=0.035
  vacuum: permittivity=1

design EMDesign1 (HFSS 3D Layout)
ports:
  Port1: Properties{Reference=Inner1.Cu:poly_46 Impedance=50ohm Magnitude=1V Phase=0deg Renormalize_Impedence="50ohm + 0i ohm" Renormalize Deembed_Distance=0mm Deembed Type="Single Strip Gap Source" HFSS_Type=Gap Orientation=Vertical Layer_Alignment=Upper Horizontal_Extent_Factor=5 Vertical_Extent_Factor=3 PEC_Launch_Width=0.05mm} Type=EdgePort
radiation setups:
  Infinite Sphere 1: Type=InfiniteSphereFarField StartTheta=0deg StartPhi=-180deg StopTheta=180deg StopPhi=180deg StepTheta=2deg StepPhi=2deg CS=1
setups:
  Setup1: SolveSetupType=HFSS PercentRefinementPerPass=30 MinNumberOfPasses=1 MinNumberOfConvergedPasses=1 Frequency=10GHz MeshSizeFactor=1.5 ViaNumSides=6 ViaMaterial=copper Style25DVia=Mesh
    sweep Sweep1: LIN 2GHz 3GHz 0.05GHz; SAbsError=0.005 ZoPercentError=1 PassivityTolerance=0.0001 UseQ3DForDC MaxSolutions=250 InterpUseSMatrix InterpUsePortImpedance InterpUseFullBasis MinSolvedFreq=0.01GHz AutoSMatOnlySolve MinFreqSMatrixOnlySolve=1MHz MagMinThreshold=0.01 FreqSweepType=kInterpolating
field plots:
  Mag_E1: E Field on Setup1 : Last Adaptive at Freq=2GHz Phase=0deg
reports:
  S Parameter Plot 1: dB(S(Port1,Port1)) vs Freq on Setup1 : Sweep1
